;;-----------------------------------------------------------------------------
;; Bindkeys for 'Annotation Browser'
;;-----------------------------------------------------------------------------
;hiSetBindKeys( "Annotation Browser" list(
;    list("<Key>Delete" "_vbAssistantDeleteSelectedInTree(abGetAssistant(hiGetCurrentWindow()))")
;)) ;; hiSetBindKeys
;;-----------------------------------------------------------------------------

;;-----------------------------------------------------------------------------
;; Bindkeys for 'Cadence Hierarchy Editor'
;;-----------------------------------------------------------------------------
;hiSetBindKeys( "Cadence Hierarchy Editor" list(
;    list("Ctrl<Key>N" "_hedTriggerActionCB(\"new\")")
;    list("Ctrl<Key>O" "_hedTriggerActionCB(\"openConfig\")")
;    list("Ctrl<Key>Q" "hiCloseWindow(hiGetCurrentWindow())")
;    list("Ctrl<Key>R" "_hedTriggerActionCB(\"openConfigRO\")")
;    list("Ctrl<Key>S" "_hedTriggerActionCB(\"save\")")
;    list("Ctrl<Key>U" "_hedTriggerActionCB(\"update\")")
;    list("Ctrl<Key>Y" "_hedTriggerActionCB(\"redo\")")
;    list("Ctrl<Key>Z" "_hedTriggerActionCB(\"undo\")")
;)) ;; hiSetBindKeys
;;-----------------------------------------------------------------------------

;;-----------------------------------------------------------------------------
;; Bindkeys for 'Command Interpreter'
;;-----------------------------------------------------------------------------
hiSetBindKeys( "Command Interpreter" list(
    list("<Key>F1" "hiHelp('window 'ciw window(1))")
    list("<Key>F2" "ddsHiOpenCdsLibEditor")
    list("<Key>F3" "hiToggleEnterForm()")
    list("<Key>F5" "ddsHiRefresh()")
    list("<Key>Help" "hiHelp('window 'ciw window(1))")
    list("<Key>`" "ddsOpenLibManager")
    list("Ctrl<Key>B" "hiSetBindKey()")
    list("Ctrl<Key>L" "hiSetFilter()")
    list("Ctrl<Key>S" "startFinder()")
    list("Ctrl<Key>C" "aedEditCDF()")
    list("Ctrl Shift<Key>L" "load \"/user/yunseong.jo/myskill/loadskill.il\"")
)) ;; hiSetBindKeys
;;-----------------------------------------------------------------------------

;;-----------------------------------------------------------------------------
;; Bindkeys for 'Graphics Browser'
;;-----------------------------------------------------------------------------
hiSetBindKeys( "Graphics Browser" list(
    list("<DrawThru1>" "geSingleSelectBox()" "geSingleSelectBox()")
    list("<DrawThru3>" "hiZoomIn()" "hiZoomIn()")
    list("<Key>BackSpace" "" "deletePoint()")
    list("<Key>Escape" "" "cancelEnterFun()")
    list("<Key>F1" "hiHelp('window deGetAppInfo(deGetEditViewType(hiGetCurrentWindow()))->appName)")
    list("<Key>F3" "" "hiToggleEnterForm()")
    list("<Key>F4" "geTogglePartialSelect()")
    list("Ctrl<Btn1Down>" "mouseSubSelectPt()" "mouseSubSelectPt()")
    list("Ctrl<Btn4Down>" "hiZoomInAtMouse()")
    list("Ctrl<Btn5Down>" "hiZoomOutAtMouse()")
    list("Ctrl<DrawThru1>" "geSubSelectBox()" "geSubSelectBox()")
    list("Ctrl<Key>Tab" "hiLowerWindow(hiGetCurrentWindow())")
    list("None<Btn1Down>" "mouseSingleSelectPt()" "mouseAddPt(t)")
    list("None<Btn1Down>(2)" "" "mouseFinishPt()")
    list("None<Btn2Down>" "hiRepeat()")
    list("None<Btn3Down>" "mousePopUp()" "mousePopUp()")
    list("None<Btn3Down>(2)" "" "hiToggleEnterForm()")
    list("None<Btn4Down>" "geScroll(nil \"n\" nil)")
    list("None<Btn5Down>" "geScroll(nil \"s\" nil)")
    list("Shift<Btn1Down>" "mouseAddSelectPt()" "mouseAddSelectPt()")
    list("Shift<Btn4Down>" "geScroll(nil \"w\" nil)")
    list("Shift<Btn5Down>" "geScroll(nil \"e\" nil)")
    list("Shift<DrawThru1>" "geAddSelectBox()" "geAddSelectBox()")
    list("Shift<DrawThru3>" "hiZoomOut()" "hiZoomOut()")
    list("Shift<Key>F4" "geToggleAreaSelectOption()")

    ;; Empty bindkeys (typically inserted when a bindkey is redefined or deleted)
    list("Shift<Btn2Down>" "")
)) ;; hiSetBindKeys
;;-----------------------------------------------------------------------------

;;-----------------------------------------------------------------------------
;; Bindkeys for 'Layout'
;; Inherited by:
;;             * PcellIDE Layout
;;             * VLS-GXL
;;             * Virtuoso XL
;;             * adegxl-maskLayout
;;             * adexl-maskLayout
;;             * assembler-maskLayout
;;             * explorer-maskLayout
;;-----------------------------------------------------------------------------
hiSetBindKeys( "Layout" list(
    list("<DrawThru1>" "geSingleSelectBox()" "geSingleSelectBox()")
    list("<DrawThru2>" "hiDynamicPanGrabbing()" "_cmdOptionDrawThru2()")
    list("<DrawThru3>" "hiZoomIn()" "hiZoomIn()")
    list("<Key>#" "hiToggleAnchorMagnifier()")
    list("<Key>'" "hiUpdateMagOptions()")
    list("<Key>+" "leIncrementStopLevelByOne(hiGetCurrentWindow())")
    list("<Key>-" "_leUnmarkNetAllCB()")
    ;list("<Key>." "leToggleMagnifier()")
    list("<Key>0" "leHiUnmarkNet()")
    ;list("<Key>1" "leSetEntryLayer(\"M1\")" "drdEnablePixelThreshold(!drdIsPixelThresholdEnabled())")
    list("<Key>1" "leSetEntryLayer(\"M1\")")
    list("<Key>2" "leSetEntryLayer(\"M2\")")
    list("<Key>3" "leSetEntryLayer(\"M3\")")
    list("<Key>4" "leSetEntryLayer(\"M4\")")
    list("<Key>5" "leSetEntryLayer(\"M5\")")
    list("<Key>6" "leSetEntryLayer(\"M6\")")
    list("<Key>7" "leSetEntryLayer(\"M7\")")
    list("<Key>8" "leSetEntryLayer(\"IA\")")
    ;list("<Key>9" "leHiMarkNet()")
    list("<Key>9" "lntHiNetTracer()")
    list("<Key>A" "leHiQuickAlign()")
    list("<Key>B" "leReturnToLevel()")
    list("<Key>BackSpace" "deletePoint()" "deletePoint()")
    list("<Key>C" "leHiCopy()")
    list("<Key>D" "geSubSelectPoint()")
    list("<Key>Delete" "leHiDelete()" "leHiDelete()")
    list("<Key>Down" "geScroll(nil \"s\"    nil)")
    list("<Key>E" "leHiEditDisplayOptions()")
    list("<Key>Escape" "" "cancelEnterFun()")
    list("<Key>F" "hiZoomAbsoluteScale(hiGetCurrentWindow() 0.9)")
    list("<Key>F1" "hiHelp('window deGetAppInfo(deGetEditViewType(hiGetCurrentWindow()))->appName)")
    list("<Key>F10" "mgc_calibre_run_drc")
    list("<Key>F11" "mgc_calibre_run_lvs")
    list("<Key>F12" "mgc_calibre_run_xact")
    list("<Key>F2" "geSave()")
    list("<Key>F3" "leHiSaveACopy(hiGetCurrentWindow())" "hiToggleEnterForm()")
    list("<Key>F4" "geTogglePartialSelect()")
    list("<Key>F5" "deFileOpen()")
    list("<Key>F6" "leToggleMaintainConnections()")
    list("<Key>F7" "leHiEditDRDRuleOptions()")
    list("<Key>F9" "geToggleDisplayResolution()")
    list("<Key>G" "leToggleGravity()")
    list("<Key>H" "leHiRepeatCopy()")
    list("<Key>I" "leHiCreateInst()")
    list("<Key>J" "geSelObjectsPartiallySelected()")
    list("<Key>K" "leHiCreateMeasurement()")
    list("<Key>KP_Add" "leHiSetRefPoint()")
    list("<Key>KP_Divide" "drdAddTarget()" "drdAddTarget()")
    list("<Key>KP_Enter" "mouseAddPt()")
    list("<Key>KP_Equal" "legRpDelta = 0.5")
    list("<Key>KP_Multiply" "drdRemoveTarget()" "drdRemoveTarget()")
    list("<Key>KP_Subtract" "leSetRefPointInactive(geGetEditCellView())")
    list("<Key>L" "leHiCreateLabel(hiGetCurrentWindow() leGetEnv(\"labelMode\"))")
    list("<Key>Left" "geScroll(nil \"w\"    nil)")
    list("<Key>M" "leHiMove()")
    list("<Key>N" "leCycleSnapModes()")
    list("<Key>O" "leHiCreateVia()")
    list("<Key>P" "weHiInteractiveRouting()")
    list("<Key>Q" "leHiEditProp()")
    list("<Key>R" "leHiCreateRect()")
    list("<Key>R11" "geScroll(nil \"\"    nil)")
    list("<Key>R13" "geScroll(nil \"sw\"    nil)")
    list("<Key>R15" "geScroll(nil \"se\"    nil)")
    list("<Key>R4" "legRpDelta = 0.5")
    list("<Key>R5" "legRpDelta = 1.0")
    list("<Key>R6" "legRpDelta = 2.0")
    list("<Key>R7" "geScroll(nil \"nw\"    nil)")
    list("<Key>R9" "geScroll(nil \"ne\"    nil)")
    list("<Key>Right" "geScroll(nil \"e\"    nil)")
    list("<Key>S" "leHiStretch()")
    list("<Key>T" "leHiLayerTap()")
    list("<Key>Tab" "hiPan()" "leSetFocusToEditableFieldsInStatusToolbar(hiGetCurrentWindow())")
    list("<Key>U" "hiUndo()")
    list("<Key>Up" "geScroll(nil \"n\"    nil)")
    list("<Key>V" "leHiAttach()")
    list("<Key>W" "hiPrevWinView(hiGetCurrentWindow())")
    list("<Key>X" "leHiEditInPlace()")
    list("<Key>Y" "leHiYank()")
    list("<Key>Z" "hiZoomIn()")
    list("<Key>[" "leSetAllLayerVisible(nil)")
    list("<Key>]" "leSetAllLayerVisible(t)")
    list("<Key>\\" "mgc_rve_delete_markers")
    list("<Key>space" "" "leSpaceBarFunc(hiGetCurrentWindow() t)")
    list("Ctrl Shift<Btn1Down>" "hiZoomInMagnifier(hiGetCurrentWindow())")
    list("Ctrl Shift<Btn2Down>" "hiZoomOutMagnifier(hiGetCurrentWindow())")
    list("Ctrl Shift<Btn4Down>" "" "weScaleMagnifierOrIncreaseWidth()")
    list("Ctrl Shift<Btn5Down>" "" "weScaleMagnifierOrDecreaseWidth()")
    list("Ctrl Shift<Key>A" "leHiAddWireVia(hiGetCurrentWindow() \"down\")")
    list("Ctrl Shift<Key>D" "leHiP2P()")
    list("Ctrl Shift<Key>Down" "hiScaleMagnifier(0.80)")
    list("Ctrl Shift<Key>C" "leHiMakeCell()")
    list("Ctrl Shift<Key>E" "leHiAddWireVia(hiGetCurrentWindow() \"targetLayers\")")
    list("Ctrl Shift<Key>F" "leHiFlatten()")
    list("Ctrl Shift<Key>G" "weGatherBusWires(hiGetCurrentWindow())")
    list("Ctrl Shift<Key>H" "drdCompactSelSet('left)")
    list("Ctrl Shift<Key>J" "drdCompactSelSet('right)")
    list("Ctrl Shift<Key>K" "leHiClearMeasurementInHier()")
    list("Ctrl Shift<Key>M" "leHiIncrementalViolation()")
    list("Ctrl Shift<Key>N" "drdCompactSelSet('bottom)")
    list("Ctrl Shift<Key>Q" "leHiAddWireVia(hiGetCurrentWindow() \"up\")")
    list("Ctrl Shift<Key>S" "leHiCreateStrandedWire()")
    list("Ctrl Shift<Key>T" "drdCompactSelSet('target)")
    list("Ctrl Shift<Key>U" "drdCompactSelSet('top)")
    list("Ctrl Shift<Key>Up" "hiScaleMagnifier(1.25)")
    list("Ctrl Shift<Key>V" "" "leFinishWire()")
    list("Ctrl Shift<Key>W" "weHiInteractiveRouting()")
    list("Ctrl Shift<Key>X" "leHiCreateBus()")
    list("Ctrl Shift<Key>Z" "leWECycleControlWire()")
    list("Ctrl Shift<Key>space" "" "leSpaceBarFunc(hiGetCurrentWindow() \"ctrlShift\")")
    list("Ctrl<Btn1Down>" "mouseSubSelectPt()" "mouseSubSelectPt()")
    list("Ctrl<Btn2Down>" "" "cmdCtrlOption()")
    list("Ctrl<Btn4Down>" "geScroll(nil \"n\" nil)" "weScrollOrCycleUpWireViaAlignment()")
    list("Ctrl<Btn5Down>" "geScroll(nil \"s\" nil)" "weScrollOrCycleDownWireViaAlignment()")
    list("Ctrl<DrawThru1>" "geSubSelectBox()" "geSubSelectBox()")
    list("Ctrl<Key>0" "leSetEntryLayer('(M1 label))")
    list("Ctrl<Key>1" "leSetEntryLayer('(M1 label))")
    list("Ctrl<Key>2" "leSetEntryLayer('(M2 label))")
    list("Ctrl<Key>3" "leSetEntryLayer('(M3 label))")
    list("Ctrl<Key>4" "leSetEntryLayer('(M4 label))")
    list("Ctrl<Key>5" "leSetEntryLayer('(M5 label))")
    list("Ctrl<Key>6" "leSetEntryLayer('(M6 label))")
    list("Ctrl<Key>7" "leSetEntryLayer('(M7 label))")
    list("Ctrl<Key>8" "leSetEntryLayer('(IA label))")
    list("Ctrl<Key>9" "leSetEntryLayer('(IB label))")
    list("Ctrl<Key>A" "geSelectAllFig()")
    list("Ctrl<Key>B" "leBalloonToggleOnOff()")
    list("Ctrl<Key>C" "mgc_rve_end_enter_function_binding(\"Layout\")")
    list("Ctrl<Key>D" "geDeselectAllFig()")
    list("Ctrl<Key>Down" "CCSresizeWin(4)")
    list("Ctrl<Key>E" "leToggleDrdMode()")
    list("Ctrl<Key>F" "leSetStopLevelToEditLevel(hiGetCurrentWindow())")
    list("Ctrl<Key>F11" "deToggleToolbars()")
    list("Ctrl<Key>G" "leHiCreateGroup()")
    list("Ctrl<Key>H" "geDSAFreeze(hiGetCurrentWindow()  hiGetPoint(hiGetCurrentWindow()))")
    list("Ctrl<Key>I" "leBalloonCycleThru()")
    list("Ctrl<Key>J" "leHiFlip()")
    list("Ctrl<Key>K" "leToggleKeepFirstName()")
    list("Ctrl<Key>L" "" "weCWHoldWidth()")
    list("Ctrl<Key>Left" "CCSresizeWin(1)")
    list("Ctrl<Key>N" "leSetFormSnapMode(\"L90XFirst\")")
    list("Ctrl<Key>O" "geSelectViaPile()")
    list("Ctrl<Key>P" "leHiCreatePin()")
    list("Ctrl<Key>R" "_leRotateOrFlip(\"MX\")")
    list("Ctrl<Key>R11" "geScroll(nil \"\"    t)")
    list("Ctrl<Key>R13" "geScroll(nil \"sw\"    t)")
    list("Ctrl<Key>R15" "geScroll(nil \"se\"    t)")
    list("Ctrl<Key>R7" "geScroll(nil \"nw\"    t)")
    list("Ctrl<Key>R9" "geScroll(nil \"ne\"    t)")
    list("Ctrl<Key>Right" "CCSresizeWin(2)")
    list("Ctrl<Key>S" "leHiSplit()")
    list("Ctrl<Key>T" "leZoomToSelSet()")
    list("Ctrl<Key>Tab" "hiLowerWindow(hiGetCurrentWindow())")
    list("Ctrl<Key>Up" "CCSresizeWin(3)")
    list("Ctrl<Key>V" "hiFocusToCIW(hiGetCurrentWindow())")
    list("Ctrl<Key>W" "leCloseWindow()")
    list("Ctrl<Key>X" "leEIPZoomAbsoluteScale(hiGetCurrentWindow() 0.9)")
    list("Ctrl<Key>Y" "geCycleSelectNext()")
    list("Ctrl<Key>Z" "hiZoomRelativeScale(hiGetCurrentWindow() 2.0)")
    list("Ctrl<Key>space" "" "leSpaceBarFunc(hiGetCurrentWindow() \"cancel\")")
    list("Ctrl <Key>Up"      "ctrkeyu()")
    list("Ctrl <Key>Down"    "ctrkeyd()")
    list("Ctrl <Key>Left"    "ctrkeyl()")
    list("Ctrl <Key>Right"   "ctrkeyr()")
    list("None<Btn1Down>" "mouseSingleSelectPt()" "mouseAddPt(t)")
    list("None<Btn1Down>(2)" "leDoubleClick()" "mouseApplyOrFinishPoint()")
    list("None<Btn2Down>" "hiRepeat()" "cmdOption()")
    list("None<Btn3Down>" "_lxHiMousePopUp()" "_lxHiMousePopUp()")
    list("None<Btn3Down>(2)" "leHiEditProp()" "hiToggleEnterForm()")
    list("None<Btn4Down>" "hiZoomInAtMouse()")
    list("None<Btn5Down>" "hiZoomOutAtMouse()")
    list("Return" "" "mouseApplyOrFinishPoint()")
    list("Shift<Btn1Down>" "mouseAddSelectPt()" "mouseAddSelectPt()")
    list("Shift<Btn2Down>" "" "cmdShiftOption()")
    list("Shift<Btn4Down>" "geScroll(nil \"w\" nil)")
    list("Shift<Btn5Down>" "geScroll(nil \"e\" nil)")
    list("Shift<DrawThru1>" "geAddSelectBox()" "geAddSelectBox()")
    list("Shift<DrawThru3>" "hiZoomOut()" "hiZoomOut()")
    list("Shift<Key>1" "leSetEntryLayer(\"RX\")")
    list("Shift<Key>2" "leSetEntryLayer('NW\")")
    list("Shift<Key>3" "leSetEntryLayer(\"PC\")")
    list("Shift<Key>4" "leSetEntryLayer(\"BP\")")
    list("Shift<Key>A" "geSelectArea()")
    list("Shift<Key>B" "leReturn()")
    list("Shift<Key>C" "leHiChop()")
    list("Shift<Key>D" "geSubSelectBox()")
    list("Shift<Key>Down" "leMoveCursor(0           -legRpDelta)")
    list("Shift<Key>E" "leHiEditEditorOptions()")
    list("Shift<Key>F" "leSetStopLevelToMaxHierDepth(hiGetCurrentWindow())")
    list("Shift<Key>F11" "deToggleToolbars() deToggleAssistants()")
    list("Shift<Key>F4" "geToggleAreaSelectOption()")
    list("Shift<Key>F5" "leFullSelectFigOfSelSet()")
    list("Shift<Key>G" "leHiCreateGuardRing()")
    list("Shift<Key>K" "leHiClearMeasurement()")
    list("Shift<Key>Left" "leMoveCursor(-legRpDelta           0)")
    list("Shift<Key>M" "leHiMerge()")
    list("Shift<Key>N" "leGetCoordinateForm()")
    list("Shift<Key>O" "leHiRotate()")
    list("Shift<Key>P" "leHiCreatePolygon()")
    list("Shift<Key>Q" "leEditDesignProperties()")
    list("Shift<Key>R" "_leRotateOrFlip(\"MY\")")
    list("Shift<Key>R11" "leMoveCursorToRefPoint()")
    list("Shift<Key>R13" "leMoveCursor(-legRpDelta -legRpDelta)")
    list("Shift<Key>R15" "leMoveCursor( legRpDelta -legRpDelta)")
    list("Shift<Key>R7" "leMoveCursor(-legRpDelta  legRpDelta)")
    list("Shift<Key>R9" "leMoveCursor( legRpDelta  legRpDelta)")
    list("Shift<Key>Right" "leMoveCursor( legRpDelta           0)")
    list("Shift<Key>S" "leHiSearch()")
    list("Shift<Key>T" "leHiTree()")
    list("Shift<Key>U" "hiRedo()")
    list("Shift<Key>Up" "leMoveCursor(          0  legRpDelta)")
    list("Shift<Key>V" "deToggleAssistantVisibility(\"World View\")")
    list("Shift<Key>W" "hiNextWinView(hiGetCurrentWindow())")
    list("Shift<Key>X" "leHiDescend()")
    list("Shift<Key>Y" "leHiPaste()")
    list("Shift<Key>Z" "hiZoomRelativeScale(hiGetCurrentWindow() 0.5)")
    list("Shift<Key>`" "" "drdToggleSmartSnapModeForDiscreteSpacing()")
    list("Shift<Key>space" "" "leSpaceBarFunc(hiGetCurrentWindow() t t)")
    list("<Key>," "CCSresizeWin(1)" )
    list("<Key>." "CCSresizeWin(2)" )
    list("<Key>/" "CCSresizeWin(3)" )
    list("<Key>`" "ddsOpenLibManager()" )
    list("<Key>~" "hiFocusToCIW()" )

    ;; Empty bindkeys (typically inserted when a bindkey is redefined or deleted)
    list("Shift<Key>Escape" "")
)) ;; hiSetBindKeys
;;  Set the selection/visibility of poly and metal layers
;;      Set entry layer
;;      Set layer's visibility
prog((  __keyInfo __key __layer __lp __lpDrw __lpEtcs __cmd )
    foreach( __keyInfo '(
        ("`"   "PC"    "drawing"  "label")
        ("1"   "M1"    "drawing"  "label")
        ("2"   "M2"    "drawing"  "label")
        ("3"   "M3"    "drawing"  "label")
        ("4"   "M4"    "drawing"  "label")
        ("5"   "M5"    "drawing"  "label")
        ("6"   "M6"    "drawing"  "label")
        ("7"   "M7"    "drawing"  "label")
        ("8"   "IA"    "drawing"  "label")
        ("9"   "IB"    "drawing"  "label")
    )
        __key     = nth(0 __keyInfo)
        __layer   = nth(1 __keyInfo)

        sprintf(__lpDrw "list(\"%s\" \"%s\")" __layer nth(3 __keyInfo))

        __lpEtcs  = '()
        foreach( __purpose cdddr(__keyInfo)
            sprintf(__lp "list(\"%s\" \"%s\")" __layer __purpose)
            __lpEtcs  = append1(__lpEtcs __lp)
        )

        ;;  Set entry layer
        ;;    SHIFT+KEY
        hiSetBindKey("Layout" strcat("Shift<Key>" __key) strcat(
            "leSetEntryLayer(" __lpDrw ")"
        ))
        ;;hotfix
        hiSetBindKey("Layout" "<Key>#" "leSetEntryLayer(list(\"M3\" \"label\"))")
        hiSetBindKey("Layout" "<Key>@" "leSetEntryLayer(list(\"M2\" \"label\"))")

        ;;  Toggle layer visibility
        ;;    CTRL+KEY
        sprintf(__lpDrw "list(\"%s\" \"%s\")" __layer nth(2 __keyInfo))
        sprintf(__cmd "leSetLayerVisible(%s not(leIsLayerVisible(%s)))" __lpDrw __lpDrw)
        foreach( __lp __lpEtcs
            sprintf(__cmd "%s leSetLayerVisible(%s leIsLayerVisible(%s))" __cmd __lp __lpDrw)
        )
        sprintf(__cmd "%s hiRedraw()" __cmd)

        hiSetBindKey("Layout" strcat("Ctrl<Key>" __key) __cmd)

        ;;  Set one layer visible
        ;;    CTRL+SHIFT+KEY
        ;;sprintf(__cmd "leSetEntryLayer(%s) leSetAllLayerVisible(nil)" __lpDrw)
        sprintf(__cmd "leSetEntryLayer(%s) _pteHiLayerSetNoneVisible(dwindow('pteLayerPalette1))" __lpDrw)
        foreach( __lp __lpEtcs
            sprintf(__cmd "%s leSetLayerVisible(%s t)" __cmd __lp)
        )
        sprintf(__cmd "%s hiRedraw()" __cmd)

        hiSetBindKey("Layout" strcat("Ctrl Shift<Key>" __key) __cmd)
    )

;;    ;;  Toggle all layers' visibility
;;    hiSetBindKey("Layout" "Ctrl<Key>q"       strcat(
;;        "leSetAllLayerVisible(t) "
;;        "hiRedraw() "
;;    ))
;;    hiSetBindKey("Layout" "Ctrl Shift<Key>q" strcat(
;;        "leSetAllLayerVisible(nil) "
;;        "hiRedraw() "
;;    ))
;;
)
;;-----------------------------------------------------------------------------

  ;;---------------------------------------------------------------------------
  ;; Bindkeys for 'PcellIDE Layout'
  ;; Inherits from: 'Layout'
  ;;---------------------------------------------------------------------------
  hiSetBindKeys( "PcellIDE Layout" list(
      list("<DrawThru1>" "nil")
      list("<Key>#" "nil")
      list("<Key>'" "nil")
      list("<Key>." "nil")
      list("<Key>1" "nil")
      list("<Key>A" "nil")
      list("<Key>B" "nil")
      list("<Key>BackSpace" "nil")
      list("<Key>C" "nil")
      list("<Key>D" "nil")
      list("<Key>Delete" "nil" "nil")
      list("<Key>F2" "nil")
      list("<Key>F3" "nil")
      list("<Key>F5" "nil")
      list("<Key>F6" "nil")
      list("<Key>F7" "nil")
      list("<Key>H" "nil")
      list("<Key>I" "nil")
      list("<Key>KP_Add" "nil")
      list("<Key>KP_Divide" "nil")
      list("<Key>KP_Enter" "nil")
      list("<Key>KP_Equal" "nil")
      list("<Key>KP_Multiply" "nil")
      list("<Key>KP_Subtract" "nil")
      list("<Key>L" "nil")
      list("<Key>M" "nil")
      list("<Key>N" "nil")
      list("<Key>O" "nil")
      list("<Key>P" "nil")
      list("<Key>R" "nil")
      list("<Key>R4" "nil")
      list("<Key>R5" "nil")
      list("<Key>R6" "nil")
      list("<Key>S" "nil")
      list("<Key>T" "nil")
      list("<Key>U" "nil")
      list("<Key>V" "nil")
      list("<Key>X" "nil")
      list("<Key>Y" "nil")
      list("<Key>]" "nil")
      list("<Key>`" "nil")
      list("<Key>space" "nil" "nil")
      list("Ctrl Shift<Key>A" "nil")
      list("Ctrl Shift<Key>D" "nil")
      list("Ctrl Shift<Key>F" "nil")
      list("Ctrl Shift<Key>G" "nil")
      list("Ctrl Shift<Key>Q" "nil")
      list("Ctrl Shift<Key>S" "nil")
      list("Ctrl Shift<Key>Up" "nil")
      list("Ctrl Shift<Key>V" "nil")
      list("Ctrl Shift<Key>W" "nil")
      list("Ctrl Shift<Key>X" "nil")
      list("Ctrl Shift<Key>Z" "nil")
      list("Ctrl Shift<Key>space" "nil" "nil")
      list("Ctrl<DrawThru1>" "nil")
      list("Ctrl<Key>B" "nil")
      list("Ctrl<Key>E" "nil")
      list("Ctrl<Key>I" "nil")
      list("Ctrl<Key>J" "nil")
      list("Ctrl<Key>N" "nil")
      list("Ctrl<Key>P" "nil")
      list("Ctrl<Key>S" "nil")
      list("Ctrl<Key>space" "nil" "nil")
      list("None<Btn1Down>" "_pcIdeSingleSelectPt()")
      list("None<Btn1Down>(2)" "nil")
      list("None<Btn3Down>" "_pcIdeGetCxtMenu()")
      list("Return" "nil")
      list("Shift<DrawThru1>" "nil")
      list("Shift<Key>B" "nil")
      list("Shift<Key>C" "nil")
      list("Shift<Key>D" "nil")
      list("Shift<Key>Down" "nil")
      list("Shift<Key>G" "nil")
      list("Shift<Key>Left" "nil")
      list("Shift<Key>M" "nil")
      list("Shift<Key>N" "nil")
      list("Shift<Key>O" "nil")
      list("Shift<Key>P" "nil")
      list("Shift<Key>R" "nil")
      list("Shift<Key>R11" "nil")
      list("Shift<Key>R13" "nil")
      list("Shift<Key>R15" "nil")
      list("Shift<Key>R7" "nil")
      list("Shift<Key>R9" "nil")
      list("Shift<Key>Right" "nil")
      list("Shift<Key>S" "nil")
      list("Shift<Key>U" "nil")
      list("Shift<Key>Up" "nil")
      list("Shift<Key>X" "nil")
      list("Shift<Key>Y" "nil")
      list("Shift<Key>space" "" "nil")
  )) ;; hiSetBindKeys
  ;;---------------------------------------------------------------------------

;;-----------------------------------------------------------------------------
;; Bindkeys for 'Palette'
;;-----------------------------------------------------------------------------
hiSetBindKeys( "Palette" list(
    list("<Key>1" "pteSetLSActive(?layerSets pteGetLSAtPosition(0) ?turnOnVis t ?turnOnSel t ?turnOffAllVis t ?turnOffAllSel t ?deactivateOthers t)")
    list("<Key>2" "pteSetLSActive(?layerSets pteGetLSAtPosition(1) ?turnOnVis t ?turnOnSel t ?turnOffAllVis t ?turnOffAllSel t ?deactivateOthers t)")
    list("<Key>3" "pteSetLSActive(?layerSets pteGetLSAtPosition(2) ?turnOnVis t ?turnOnSel t ?turnOffAllVis t ?turnOffAllSel t ?deactivateOthers t)")
    list("<Key>4" "pteSetLSActive(?layerSets pteGetLSAtPosition(3) ?turnOnVis t ?turnOnSel t ?turnOffAllVis t ?turnOffAllSel t ?deactivateOthers t)")
    list("<Key>5" "pteSetLSActive(?layerSets pteGetLSAtPosition(4) ?turnOnVis t ?turnOnSel t ?turnOffAllVis t ?turnOffAllSel t ?deactivateOthers t)")
    list("<Key>6" "pteSetLSActive(?layerSets pteGetLSAtPosition(5) ?turnOnVis t ?turnOnSel t ?turnOffAllVis t ?turnOffAllSel t ?deactivateOthers t)")
    list("<Key>7" "pteSetLSActive(?layerSets pteGetLSAtPosition(6) ?turnOnVis t ?turnOnSel t ?turnOffAllVis t ?turnOffAllSel t ?deactivateOthers t)")
    list("<Key>8" "pteSetLSActive(?layerSets pteGetLSAtPosition(7) ?turnOnVis t ?turnOnSel t ?turnOffAllVis t ?turnOffAllSel t ?deactivateOthers t)")
    list("<Key>9" "pteSetLSActive(?layerSets pteGetLSAtPosition(8) ?turnOnVis t ?turnOnSel t ?turnOffAllVis t ?turnOffAllSel t ?deactivateOthers t)")
    list("<Key><" "pteCollapseAll()")
    list("<Key>>" "pteExpandAll()")
    list("<Key>B" "pteSetBindkeys()")
    list("<Key>D" "pteDiscardLayerSetEdition()")
    list("<Key>F10" "pteContextMenu()")
    list("<Key>F11" "pteToggleToolbars()")
    list("<Key>F12" "pteToggleAllTools()")
    list("<Key>L" "pteToggleLayerSetValidityEdition()")
    list("<Key>M" "pteToggleLayerSetEdition()")
    list("<Key>N" "pteSetLSActive(?layerSets pteGetNextLayerSets() ?turnOnVis t ?turnOnSel t ?turnOffAllVis t ?turnOffAllSel t ?deactivateOthers t)")
    list("<Key>O" "pteOpenForm(\"Options\")")
    list("<Key>P" "pteSetLSActive(?layerSets pteGetPrevLayerSets() ?turnOnVis t ?turnOnSel t ?turnOffAllVis t ?turnOffAllSel t ?deactivateOthers t)")
    list("<Key>S" "pteToggleAllSelectable()")
    list("<Key>V" "pteToggleAllVisible()")
    list("<Key>W" "pteToggleWindowSynchro()")
    list("Ctrl<Key>1" "pteToggleLSActive(?layerSet pteGetLSAtPosition(0) ?toggleVis t ?toggleSel t)")
    list("Ctrl<Key>2" "pteToggleLSActive(?layerSet pteGetLSAtPosition(1) ?toggleVis t ?toggleSel t)")
    list("Ctrl<Key>3" "pteToggleLSActive(?layerSet pteGetLSAtPosition(2) ?toggleVis t ?toggleSel t)")
    list("Ctrl<Key>4" "pteToggleLSActive(?layerSet pteGetLSAtPosition(3) ?toggleVis t ?toggleSel t)")
    list("Ctrl<Key>5" "pteToggleLSActive(?layerSet pteGetLSAtPosition(4) ?toggleVis t ?toggleSel t)")
    list("Ctrl<Key>6" "pteToggleLSActive(?layerSet pteGetLSAtPosition(5) ?toggleVis t ?toggleSel t)")
    list("Ctrl<Key>7" "pteToggleLSActive(?layerSet pteGetLSAtPosition(6) ?toggleVis t ?toggleSel t)")
    list("Ctrl<Key>8" "pteToggleLSActive(?layerSet pteGetLSAtPosition(7) ?toggleVis t ?toggleSel t)")
    list("Ctrl<Key>9" "pteToggleLSActive(?layerSet pteGetLSAtPosition(8) ?toggleVis t ?toggleSel t)")
    list("Ctrl<Key>F" "pteSetConfig(\"toggleTool\" \"Search\")")
    list("Ctrl<Key>N" "pteFindNext()")
    list("Ctrl<Key>P" "pteFindPrev()")
    list("Ctrl<Key>S" "pteTogglePropagateAllSelectable()")
    list("Ctrl<Key>V" "pteTogglePropagateAllVisible()")
    list("Shift<Key>A" "pteOpenForm(\"Save As Layer Set\")")
    list("Shift<Key>F11" "pteTogglePanels()")
    list("Shift<Key>S" "pteSaveLayerSet()")
)) ;; hiSetBindKeys
;;-----------------------------------------------------------------------------

;;-----------------------------------------------------------------------------
;; Bindkeys for 'Read HDL'
;;-----------------------------------------------------------------------------
hiSetBindKeys( "Read HDL" list(
    list("Ctrl<Key>E" "schHDLReturn()")
    list("Ctrl<Key>S" "hiSaveAsViewfile()")
)) ;; hiSetBindKeys
;;-----------------------------------------------------------------------------

;;-----------------------------------------------------------------------------
;; Bindkeys for 'Schematics'
;; Inherited by:
;;             * PcellIDE Schematic
;;             * Schematics XL
;;             * adegxl-schematic
;;             * adexl-schematic
;;             * assembler-schematic
;;             * explorer-schematic
;;-----------------------------------------------------------------------------
hiSetBindKeys( "Schematics" list(
	; mouse control
    list("<DrawThru1>" "geSingleSelectBox()" "geSingleSelectBox()")
    list("<DrawThru2>" "hiDynamicPanGrabbing()" "hiDynamicPanGrabbing()")
    list("<DrawThru3>" "hiZoomIn()" "hiZoomIn()")
    list("<Key>#" "hiToggleAnchorMagnifier()")
    list("<Key>'" "hiUpdateMagOptions()")

	; number
	;list("<Key>." "hiToggleMagnifier()")
    ;list("<Key>1" "schHiChangeEditMode(\"a\")")
    list("<Key>1" "CCStoggleEditReadMode()")
    list("Ctrl<Key>1" "CCSschSnapGrid(1)")
    list("Ctrl<Key>2" "CCSschSnapGrid(0)")
    ;list("<Key>2" "schHiChangeEditMode(\"r\")")
    list("<Key>3" "_axlInstallMainAndSubApps(\"explorer\")")
    list("<Key>4" "lxLaunchLayoutXL()")
    list("<Key>5" "schHiRouteFlightLine()")
    list("<Key>8" "schHiHiliteLabel(\"instance\" \"on\")")
    list("<Key>9" "geEnterAddNetProbe()")
    list("<Key>0" "geEnterDeleteNetProbe()")
    list("<Key>Page_Down" "CCSadjustBus(1 -1)")
    list("<Key>Page_Up" "CCSadjustBus(1 1)")
    list("Shift<Key>Page_Down" "CCSadjustBus(2 -1)")
    list("Shift<Key>Page_Up" "CCSadjustBus(2 1)")
    list("<Key>-" "geDeleteAllProbe(getCurrentWindow() t)")
    list("<Key>=" "schHiOpenSymbolOrSchematicView(geGetEditCellView() hiGetCurrentWindow())")
    ;list("<Key>A" "geSingleSelectPoint()")
    list("<Key>A" "sevChangeOutsOnSchematic(sevSession(hiGetCurrentWindow()) 'plot)")
    list("<Key>B" "schHiCreateBlockInst()")
    list("<Key>BackSpace" "schHiDelete()" "deletePoint()")
    list("<Key>C" "schHiCopy()")
    list("<Key>D" "geSubSelectPoint()")
    list("<Key>Delete" "schHiDelete()")
    list("<Key>Down" "geScroll(nil \"s\" nil)")
    ;list("<Key>E" "schHiDescend()")
    list("<Key>E" "_schHiDescendViewType(?mode \"auto\" ?viewType \"schematic\" ?canvasType \"current tab\")")
    list("<Key>Escape" "" "cancelEnterFun()")
    list("<Key>F" "schZoomFit(1.0 0.9)")
    list("<Key>F1" "hiHelp('window deGetAppInfo(deGetEditViewType(hiGetCurrentWindow()))->appName)")
    ;list("<Key>F9" "SEC_CWSelectSignal()")
    list("<Key>F9" "SMatCPtoCustomWaveView()")
    list("<Key>F11" "deToggleAssistants()")
    list("<Key>F3" "" "hiToggleEnterForm()")
    list("<Key>F4" "geTogglePartialSelect()")
    ;list("<Key>F6" "hiRedraw()")
	list("<Key>F6" "CCSShortPin(\"VDD\" \"VNW\" \"VDD\") CCSShortPin(\"VSS\" \"VPW\" \"VSS\")")
    list("<Key>G" "schHiFindMarker()")
    list("<Key>H" "schHiHiliteLabel(\"wire\" \"on\")")
    list("<Key>I" "schHiCreateInst()")
	list("<Key>K"   "_schHiCreateMeasurement(hiGetCurrentWindow())")
    list("<Key>L" "schHiCreateWireLabel()")
    list("<Key>Left" "geScroll(nil \"w\" nil)")
    list("<Key>M" "schHiStretch()")
    list("<Key>N" "schHiCreateNoteShape()")
    list("<Key>O" "schHiDisplayOptions()")
    list("<Key>P" "schHiCreatePin()")
    list("<Key>Q" "schHiObjectProperty()" "schHiObjectProperty()")
    list("<Key>R" "schHiRotate(t)" "schSetEnv(\"rotate\" t)")
    list("<Key>Right" "geScroll(nil \"e\" nil)")
    list("<Key>S" "" "schSnapToConn()")
    list("<Key>T" "schHiEditText()")
    list("<Key>U" "hiUndo()")
    list("<Key>Up" "geScroll(nil \"n\" nil)")
    list("<Key>V" "hiVectorPan()")
    list("<Key>W" "schHiCreateWire(0.0)")
    ;list("<Key>X" "schHiCheck(\"run\")")
    list("<Key>X" "schHiEditInPlace()")
    list("<Key>Z" "hiZoomIn()")
    ;list("<Key>[" "hiZoomRelativeScale(getCurrentWindow() 0.8)")
    list("<Key>[" "schHiFontUpdate(?increase nil)")
    ;list("<Key>]" "hiZoomRelativeScale(getCurrentWindow() 1.25)")
    list("<Key>]" "schHiFontUpdate(?increase t)")
    list("<Key>space" "schHiCreateWireStubs()")
    list("Ctrl Shift<Btn1Down>" "hiZoomInMagnifier(hiGetCurrentWindow())")
    list("Ctrl Shift<Btn2Down>" "hiZoomOutMagnifier(hiGetCurrentWindow())")
    list("Ctrl Shift<Btn4Down>" "_schScaleMagnifier(1.25)")
    list("Ctrl Shift<Btn5Down>" "_schScaleMagnifier(0.80)")
    list("Ctrl Shift<Key>A" "schSelectByLine()")
    list("Ctrl Shift<Key>Down" "hiScaleMagnifier(0.80)")
    list("Ctrl Shift<Key>G" "schHiSnapToGrid()")
	list("Ctrl Shift<Key>S" "CCSToggleSnapMode()")
    list("Ctrl Shift<Key>Up" "hiScaleMagnifier(1.25)")
    list("Ctrl Shift<Key>Z" "hiNextWinView(hiGetCurrentWindow())")
    list("Ctrl Shift<Key>Q"  "lblupdate(2)")
    list("Ctrl Shift<Key>W"  "CCScopyName(?hier t)")
    list("Ctrl<Btn1Down>" "mouseSubSelectPt()" "mouseSubSelectPt()")
    list("Ctrl<Btn4Down>" "geScroll(nil \"n\" nil)")
    list("Ctrl<Btn5Down>" "geScroll(nil \"s\" nil)")
    list("Ctrl<DrawThru1>" "schDirectEdit(3)" "geSubSelectBox()")
    list("Ctrl<Key>A" "schSelectAllFig()")
    list("Ctrl<Key>B" "annToggleInfoBalloonVisibilityStatus()")
    list("Ctrl<Key>C" "mgc_rve_end_enter_function_binding(\"Schematics\")")
    list("Ctrl<Key>D" "schDeselectAllFig()")
    list("Ctrl<Key>E" "schHiReturn()")
    ;list("Ctrl<Key>F" "schSetSelectOptions()")
    list("Ctrl<Key>F" "schHiFind()")
    list("Ctrl<Key>F11" "deToggleToolbars()")
    list("Ctrl<Key>G" "geHiDeleteMarker()")
    list("Ctrl<Key>R" "" "schSetEnv(\"upsideDown\" t)")
    list("<Key>S" "_schHiSaveAs()")
    list("Ctrl<Key>T" "schHiZoomToSelSet()")
    list("Ctrl<Key>Tab" "hiLowerWindow(hiGetCurrentWindow())")
    list("Ctrl<Key>V" "hiFocusToCIW(hiGetCurrentWindow())")
    list("Ctrl<Key>Z" "hiZoomOut()")
    list("Ctrl <Key>Q"       "nextinst(1)")
    list("Ctrl <Key>W"       "CCScopyName()")
    list("None<Btn1Down>" "schSingleSelectPt()" "mouseAddPt(t)")
    list("None<Btn1Down>(2)" "schHiDefaultAction()" "schMouseApplyOrFinish()")
    list("None<Btn2Down>" "hiRepeat()" "schCmdOption()")
    list("None<Btn3Down>" "schHiMousePopUp()" "schHiMousePopUp()")
    list("None<Btn3Down>(2)" "" "hiToggleEnterForm()")
    list("None<Btn4Down>" "hiZoomInAtMouse()")
    list("None<Btn5Down>" "hiZoomOutAtMouse()")
    list("Return" "" "schMouseApplyOrFinish()")
    list("Shift<Btn1Down>" "schAddSelectPt()" "mouseAddSelectPt()")
    list("Shift<Btn1Down>(2)" "schExtendSelectPt()")
    list("Shift<Btn2Down>" "" "schShiftCmdOption()")
    list("Shift<Btn4Down>" "geScroll(nil \"w\" nil)")
    list("Shift<Btn5Down>" "geScroll(nil \"e\" nil)")
    list("Shift<DrawThru1>" "schDirectEdit(2)" "geAddSelectBox()")
    list("Shift<DrawThru3>" "hiZoomOut()" "hiZoomOut()")
    list("Shift<Key>8" "schHiHiliteLabel(\"instance\" \"off\")")
    ;list("Shift<Key>A" "schSingleSelectBox()")
    list("Shift<Key>A" "sevChangeOutsOnSchematic(sevSession(hiGetCurrentWindow()) 'save)")
    list("Shift<Key>B" "annPinCurrentInfoBalloon(hiGetCurrentWindow())")
    list("Shift<Key>D" "schSubSelectBox()")
    list("Shift<Key>Delete" "schHiIgnore()")
    list("Shift<Key>E" "schHiDescendEdit()")
    list("Shift<Key>F" "hiZoomAbsoluteScale(getCurrentWindow() 0.9)")
    list("Shift<Key>F11" "deToggleAssistants() deToggleToolbars()")
    list("Shift<Key>F4" "geToggleAreaSelectOption()")
    list("Shift<Key>G" "schHiFindMarker()")
    list("Shift<Key>H" "schHiHiliteLabel(\"wire\" \"off\")")
	list("Shift<Key>K"  "_schHiClearAllMeasurement(hiGetCurrentWindow())")
    list("Shift<Key>L" "guiAddAffix()")
    list("Shift<Key>M" "schHiMove()")
    list("Shift<Key>N" "schHiCreateNoteLabel()")
    list("Shift<Key>O" "schHiEditorOptions()")
    list("Shift<Key>P" "CCSschHiCreatePinFromLabels()")
    list("Shift<Key>Q" "schHiCellViewProperty()" "schHiCellViewProperty()")
    list("Shift<Key>R" "" "schSetEnv(\"sideways\" t)")
    list("Shift<Key>S" "schHiEditSheetSize()")
    list("Shift<Key>T" "schHiTree()")
    list("Shift<Key>U" "hiRedo()")
    list("Shift<Key>V" "schHiViewToView()")
    list("Shift<Key>W" "schHiCreateWire(schGetEnv(\"defWideWireWidth\"))")
    list("Shift<Key>X" "schHiCheckAndSave()")
    list("Shift<Key>Z" "hiPrevWinView(hiGetCurrentWindow())")
    ;list("Shift<Key>space" "add_noConn()")
    list("Ctrl<Key>P" "CCSaddNoConn()")
    list("<Key>," "CCSresizeWin(1)" )
    list("<Key>." "CCSresizeWin(2)" )
    list("<Key>/" "CCSresizeWin(3)" )
    list("<Key>`" "ddsOpenLibManager()" )
    list("<Key>~" "hiFocusToCIW()" )
	list("<Key>F7" "SEC_CWSelectSignal()")

    ;; Empty bindkeys (typically inserted when a bindkey is redefined or deleted)
    list("<Key>Tab" "")
    list("Shift<Key>Backtab" "")
    list("Shift<Key>Tab" "")
    ;;list("Shift<Key>V" "_deToggleAssistant(\"World View\")")
)) ;; hiSetBindKeys
;;-----------------------------------------------------------------------------

  ;;---------------------------------------------------------------------------
  ;; Bindkeys for 'PcellIDE Schematic'
  ;; Inherits from: 'Schematics'
  ;;---------------------------------------------------------------------------
  hiSetBindKeys( "PcellIDE Schematic" list(
      list("<DrawThru1>" "nil")
      list("<Key>#" "nil")
      list("<Key>'" "nil")
      list("<Key>." "nil")
      list("<Key>5" "nil")
      list("<Key>8" "nil")
      list("<Key>9" "nil")
      list("<Key>=" "nil")
      list("<Key>B" "nil")
      list("<Key>BackSpace" "nil")
      list("<Key>C" "nil")
      list("<Key>D" "nil")
      list("<Key>Delete" "nil")
      list("<Key>E" "nil")
      list("<Key>H" "nil")
      list("<Key>I" "nil")
      list("<Key>L" "nil")
      list("<Key>M" "nil")
      list("<Key>N" "nil")
      list("<Key>P" "nil")
      list("<Key>R" "nil" "nil")
      list("<Key>S" "" "nil")
      list("<Key>T" "nil")
      list("<Key>U" "nil")
      list("<Key>V" "nil")
      list("<Key>W" "nil")
      list("<Key>X" "nil")
      list("<Key>space" "nil")
      list("Ctrl Shift<Btn4Down>" "nil")
      list("Ctrl Shift<Btn5Down>" "nil")
      list("Ctrl Shift<Key>Down" "nil")
      list("Ctrl Shift<Key>Up" "nil")
      list("Ctrl Shift<Key>Z" "nil")
      list("Ctrl<DrawThru1>" "nil")
      list("Ctrl<Key>E" "nil")
      list("Ctrl<Key>G" "nil")
      list("Ctrl<Key>R" "" "nil")
      list("Ctrl<Key>S" "nil")
      list("None<Btn1Down>" "_pcIdeSingleSelectPt()")
      list("None<Btn1Down>(2)" "" "nil")
      list("None<Btn2Down>" "" "nil")
      list("None<Btn3Down>" "_pcIdeGetCxtMenu()" "nil")
      list("Shift<Btn1Down>" "nil")
      list("Shift<Btn1Down>(2)" "nil")
      list("Shift<Btn2Down>" "" "nil")
      list("Shift<DrawThru1>" "nil")
      list("Shift<Key>8" "nil")
      list("Shift<Key>D" "nil")
      list("Shift<Key>E" "nil")
      list("Shift<Key>H" "nil")
      list("Shift<Key>K" "nil")
      list("Shift<Key>L" "nil")
      list("Shift<Key>M" "nil")
      list("Shift<Key>N" "nil")
      list("Shift<Key>R" "" "nil")
      list("Shift<Key>S" "nil")
      list("Shift<Key>U" "nil")
      list("Shift<Key>W" "nil")
      list("Shift<Key>X" "nil")
  )) ;; hiSetBindKeys
  ;;---------------------------------------------------------------------------

;;-----------------------------------------------------------------------------
;; Bindkeys for 'Show File'
;;-----------------------------------------------------------------------------
hiSetBindKeys( "Show File" list(
    list("<Key>End" "hiScrollWindowBottom(hiGetCurrentWindow())")
    list("<Key>Next" "hiScrollWindowDown(hiGetCurrentWindow())")
    list("<Key>Prior" "hiScrollWindowUp(hiGetCurrentWindow())")
    list("Ctrl<Key>A" "_hiSelectAll(hiGetCurrentWindow())")
    list("Ctrl<Key>B" "hiScrollWindowUp(hiGetCurrentWindow())")
    list("Ctrl<Key>C" "_hiCopy(hiGetCurrentWindow())")
    list("Ctrl<Key>F" "hiDisplayForm(hiSearchForm)")
    list("Ctrl<Key>G" "hiDisplayForm(hiGoToLineForm)")
    list("Ctrl<Key>Insert" "_hiCopy(hiGetCurrentWindow())")
    list("Ctrl<Key>O" "hiOpenNextFile()")
    list("Ctrl<Key>S" "hiSaveViewfile()")
    list("Shift<Key>G" "hiScrollWindowBottom(hiGetCurrentWindow())")
)) ;; hiSetBindKeys
;;-----------------------------------------------------------------------------

;;-----------------------------------------------------------------------------
;; Bindkeys for 'Symbol'
;; Inherited by:
;;             * PcellIDE Symbol
;;             * Symbol XL
;;-----------------------------------------------------------------------------
hiSetBindKeys( "Symbol" list(
	list("<DrawThru1>" "geSingleSelectBox()" "geSingleSelectBox()")
    list("<DrawThru2>" "hiDynamicPanGrabbing()" "hiDynamicPanGrabbing()")
    list("<DrawThru3>" "hiZoomIn()" "hiZoomIn()")
    list("<Key>#" "hiToggleAnchorMagnifier()")
    list("<Key>'" "hiUpdateMagOptions()")
    ;list("<Key>." "hiToggleMagnifier()")
    list("<Key>1" "CCSToggleEditReadMode()")
    ;list("<Key>1" "schHiChangeEditMode(\"a\")")
    ;list("<Key>2" "schHiChangeEditMode(\"r\")")
    list("<Key>9" "geEnterAddNetProbe()")
    list("<Key>=" "schHiOpenSymbolOrSchematicView(geGetEditCellView() hiGetCurrentWindow())")
    list("<Key>A" "geSingleSelectPoint()")
    list("<Key>BackSpace" "schHiDelete()" "deletePoint()")
    list("<Key>C" "schHiCopy()")
    list("<Key>D" "geSubSelectPoint()")
    list("<Key>Delete" "schHiDelete()")
    list("<Key>Down" "geScroll(nil \"s\" nil)")
    list("<Key>Escape" "" "cancelEnterFun()")
    list("<Key>F" "schZoomFit(1.0 0.9)")
    list("<Key>F1" "hiHelp('window deGetAppInfo(deGetEditViewType(hiGetCurrentWindow()))->appName)")
    list("<Key>F11" "deToggleAssistants()")
    list("<Key>F3" "" "hiToggleEnterForm()")
    list("<Key>F4" "geTogglePartialSelect()")
    list("<Key>F6" "hiRedraw()")
    list("<Key>G" "schHiFindMarker()")
    list("<Key>L" "schHiCreateSymbolLabel()")
    list("<Key>Left" "geScroll(nil \"w\" nil)")
    list("<Key>M" "schHiSymStretch()")
    list("<Key>N" "schHiCreateNoteShape()")
    list("<Key>O" "schHiDisplayOptions()")
    list("<Key>P" "schHiCreateSymbolPin()")
    list("<Key>Q" "schHiObjectProperty()" "schHiObjectProperty()")
    list("<Key>R" "schHiRotate(t)" "schSetEnv(\"rotate\" t)")
    list("<Key>Right" "geScroll(nil \"e\" nil)")
    list("<Key>T" "schHiEditText()")
    list("<Key>U" "hiUndo()")
    list("<Key>Up" "geScroll(nil \"n\" nil)")
    list("<Key>V" "hiVectorPan()")
    list("<Key>X" "schHiVIC()")
    list("<Key>Z" "hiZoomIn()")
    ;list("<Key>[" "hiZoomRelativeScale(getCurrentWindow() 0.8)")
    list("<Key>[" "schHiFontUpdate(?increase nil)")
    ;list("<Key>]" "hiZoomRelativeScale(getCurrentWindow() 1.25)")
    list("<Key>]" "schHiFontUpdate(?increase t)")
    list("Ctrl Shift<Btn1Down>" "hiZoomInMagnifier(hiGetCurrentWindow())")
    list("Ctrl Shift<Btn2Down>" "hiZoomOutMagnifier(hiGetCurrentWindow())")
    list("Ctrl Shift<Btn4Down>" "hiScaleMagnifier(1.25)")
    list("Ctrl Shift<Btn5Down>" "hiScaleMagnifier(0.80)")
    list("Ctrl Shift<Key>Down" "_schScaleMagnifier(0.80)")
	list("Ctrl Shift<Key>S" "CCSToggleSnapMode()")
    list("Ctrl Shift<Key>Up" "_schScaleMagnifier(1.25)")
    list("Ctrl Shift<Key>Z" "hiNextWinView(hiGetCurrentWindow())")
    list("Ctrl<Btn1Down>" "mouseSubSelectPt()" "mouseSubSelectPt()")
    list("Ctrl<Btn4Down>" "geScroll(nil \"n\" nil)")
    list("Ctrl<Btn5Down>" "geScroll(nil \"s\" nil)")
    list("Ctrl<DrawThru1>" "schDirectEdit(3)" "geSubSelectBox()")
    list("Ctrl<Key>A" "schSelectAllFig()")
    list("Ctrl<Key>D" "schDeselectAllFig()")
    list("Ctrl<Key>E" "schHiReturn()")
    list("Ctrl<Key>F" "schSetSelectOptions()")
    list("Ctrl<Key>F11" "deToggleToolbars()")
    list("Ctrl<Key>G" "geHiDeleteMarker()")
    list("Ctrl<Key>R" "" "schSetEnv(\"upsideDown\" t)")
    list("Ctrl<Key>S" "_schHiSaveAs()")
    list("Ctrl<Key>T" "schHiZoomToSelSet()")
    list("Ctrl<Key>Tab" "hiLowerWindow(hiGetCurrentWindow())")
    list("Ctrl<Key>V" "hiFocusToCIW(hiGetCurrentWindow())")
    list("Ctrl<Key>Z" "hiZoomOut()")
    list("None<Btn1Down>" "mouseSingleSelectPt()" "mouseAddPt(t)")
    list("None<Btn1Down>(2)" "schHiDefaultAction()" "schMouseApplyOrFinish()")
    list("None<Btn2Down>" "hiRepeat()" "schCmdOption()")
    list("None<Btn3Down>" "schHiMousePopUp()" "schHiMousePopUp()")
    list("None<Btn3Down>(2)" "" "hiToggleEnterForm()")
    list("None<Btn4Down>" "hiZoomInAtMouse()")
    list("None<Btn5Down>" "hiZoomOutAtMouse()")
    list("Return" "" "schMouseApplyOrFinish()")
    list("Shift<Btn1Down>" "mouseAddSelectPt()" "mouseAddSelectPt()")
    list("Shift<Btn2Down>" "" "schShiftCmdOption()")
    list("Shift<Btn4Down>" "geScroll(nil \"w\" nil)")
    list("Shift<Btn5Down>" "geScroll(nil \"e\" nil)")
    list("Shift<DrawThru1>" "schDirectEdit(2)" "geAddSelectBox()")
    list("Shift<DrawThru3>" "hiZoomOut()" "hiZoomOut()")
    list("Shift<Key>A" "schSingleSelectBox()")
    list("Shift<Key>D" "schSubSelectBox()")
    list("Shift<Key>F" "hiZoomAbsoluteScale(getCurrentWindow() 0.9)")
    list("Shift<Key>F11" "deToggleAssistants() deToggleToolbars()")
    list("Shift<Key>F4" "geToggleAreaSelectOption()")
    list("Shift<Key>G" "schHiFindMarker()")
    list("Shift<Key>L" "schHiCreateNoteLabel()")
    list("Shift<Key>M" "schHiMove()")
    list("Shift<Key>N" "schHiCreateNoteLabel()")
    list("Shift<Key>O" "schHiEditorOptions()")
    list("Shift<Key>Q" "schHiCellViewProperty()" "schHiCellViewProperty()")
    list("Shift<Key>R" "" "schSetEnv(\"sideways\" t)")
    list("Shift<Key>S" "_schHiSave()")
    list("Shift<Key>U" "hiRedo()")
    list("Shift<Key>V" "_deToggleAssistant(\"World View\")")
    list("Shift<Key>X" "schHiVICAndSave()")
    list("Shift<Key>Z" "hiPrevWinView(hiGetCurrentWindow())")
    list("<Key>," "CCSresizeWin(1)" )
    list("<Key>." "CCSresizeWin(2)" )
    ;list("Ctrl<Key>Up" "CCSresizeWin(3)" )
    list("<Key>/" "CCSresizeWin(3)" )
    list("<Key>`" "ddsOpenLibManager()" )
    list("<Key>~" "hiFocusToCIW()" )

    ;; Empty bindkeys (typically inserted when a bindkey is redefined or deleted)
    list("<Key>Tab" "")
    list("Shift<Btn1Down>(2)" "")
    list("Shift<Key>Backtab" "")
    list("Shift<Key>Tab" "")
)) ;; hiSetBindKeys
;;-----------------------------------------------------------------------------

  ;;---------------------------------------------------------------------------
  ;; Bindkeys for 'PcellIDE Symbol'
  ;; Inherits from: 'Symbol'
  ;;---------------------------------------------------------------------------
  hiSetBindKeys( "PcellIDE Symbol" list(
      list("<DrawThru1>" "nil")
      list("<Key>#" "nil")
      list("<Key>'" "nil")
      list("<Key>." "nil")
      list("<Key>9" "nil")
      list("<Key>=" "nil")
      list("<Key>BackSpace" "nil")
      list("<Key>C" "nil")
      list("<Key>D" "nil")
      list("<Key>Delete" "nil")
      list("<Key>L" "nil")
      list("<Key>M" "nil")
      list("<Key>N" "nil")
      list("<Key>P" "nil")
      list("<Key>R" "nil" "nil")
      list("<Key>T" "nil")
      list("<Key>U" "nil")
      list("<Key>X" "nil")
      list("Ctrl Shift<Btn4Down>" "nil")
      list("Ctrl Shift<Btn5Down>" "nil")
      list("Ctrl Shift<Key>Down" "nil")
      list("Ctrl Shift<Key>Up" "nil")
      list("Ctrl Shift<Key>Z" "nil")
      list("Ctrl<DrawThru1>" "nil")
      list("Ctrl<Key>E" "nil")
      list("Ctrl<Key>G" "nil")
      list("Ctrl<Key>R" "" "nil")
      list("Ctrl<Key>S" "nil")
      list("None<Btn1Down>" "_pcIdeSingleSelectPt()")
      list("None<Btn1Down>(2)" "" "nil")
      list("None<Btn2Down>" "" "nil")
      list("None<Btn3Down>" "_pcIdeGetCxtMenu()" "nil")
      list("Shift<Btn2Down>" "" "nil")
      list("Shift<DrawThru1>" "nil")
      list("Shift<Key>D" "nil")
      list("Shift<Key>K" "nil")
      list("Shift<Key>L" "nil")
      list("Shift<Key>M" "nil")
      list("Shift<Key>N" "nil")
      list("Shift<Key>R" "" "nil")
      list("Shift<Key>S" "nil")
      list("Shift<Key>U" "nil")
      list("Shift<Key>X" "nil")
      list("Shift<Key>Z" "nil")
  )) ;; hiSetBindKeys
  ;;---------------------------------------------------------------------------
